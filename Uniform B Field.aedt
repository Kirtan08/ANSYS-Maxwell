# Ansys Electronics Desktop project, version 2019.1
materials:
  vacuum: permittivity=1

design Uniform_B_Field_axisymmetric (Maxwell 2D, Magnetostatic, about Z geometry, model units mm)
variables:
  OD = 20mm
  ID = 10mm
  height = 10mm
  B_ext = 1tesla
geometry:
  Rectangle1 [vacuum] = rectangle(corner=(ID/2, 0mm, 0mm), z_size=height, x_size=(OD/2) - (ID/2))
boundaries and excitations:
  VectorPotential1: Vector Potential Edges=Rectangle1.edge(x at corner) Value="(1/2) * (B_ext/1tesla)*(ID/2/1meter)^2"
  VectorPotential2: Vector Potential Edges=Rectangle1.edge(x opposite corner) Value="(1/2) * (B_ext/1tesla)*(OD/2/1meter)^2"
mesh:
  initial mesh: MeshMethod=AnsoftTAU
setups:
  Setup1: Magnetostatic MaximumPasses=10 MinimumPasses=2 MinimumConvergedPasses=1 PercentRefinement=30 PercentError=1 NonLinearResidual=0.0001
field plots:
  B_Vector1: B over Rectangle1 on Setup1 : LastAdaptive

design Uniform_B_Field_Cartesian (Maxwell 2D, Magnetostatic, XY geometry, model units mm)
variables:
  B_ext = 1tesla
  Length = 10mm
  Width = 10mm
geometry:
  Rectangle1 [vacuum] = rectangle(corner=(0mm, 0mm, 0mm), x_size=Width, y_size=Length)
boundaries and excitations:
  VectorPotential1: Vector Potential Edges=Rectangle1.edge(x at corner) Value=(B_ext/1tesla)*(Length/1meter)
  VectorPotential2: Vector Potential Edges=Rectangle1.edge(x opposite corner) Value=0
mesh:
  initial mesh: MeshMethod=AnsoftTAU
setups:
  Setup1: Magnetostatic MaximumPasses=10 MinimumPasses=2 MinimumConvergedPasses=1 PercentRefinement=30 PercentError=1 NonLinearResidual=0.0001
field plots:
  B_Vector1: B over Rectangle1 on Setup1 : LastAdaptive
