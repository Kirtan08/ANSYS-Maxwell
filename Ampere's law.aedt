# Ansys Electronics Desktop project, version 2019.1
materials:
  copper: permeability=0.999991 conductivity=58000000
  vacuum: permittivity=1

design ampere's law (Maxwell 2D, Magnetostatic, XY geometry, model units mm)
geometry:
  Conductor [copper] = circle(normal=Z, centre=(0mm, 0mm, 0mm), radius=5mm)
  Region [copper] = region(percentage_offset: +X=200, -X=200, +Y=200, -Y=200, +Z=0, -Z=0)
  Traverse_Path [vacuum] = circle(normal=Z, centre=(0mm, 0mm, 0mm), radius=15mm)
  Traverse_Path_1 = object_from(Traverse_Path.edge(1 of 1))
boundaries and excitations:
  Balloon1: Balloon Edges=Region.edge(all 4)
  Current1: Current Objects=Conductor Current=500mA IsPositive=true
mesh:
  initial mesh: MeshMethod=AnsoftTAU
setups:
  Setup1: Magnetostatic MaximumPasses=10 MinimumPasses=2 MinimumConvergedPasses=1 PercentRefinement=30 PercentError=1 ExpressionCache{CacheItem{Title=NI1 Expression=NI TraceID=111 ReportType=9}} ConstantDelta=0s NonLinearResidual=0.0001
field calculator expressions:
  NI = Fundamental_Quantity(21) | Tangent | Dot | EnterLine(Traverse_Path_1) | LineValue | Integrate
  H_mag = Fundamental_Quantity(21) | Mag
  Mag_H_smooth = Fundamental_Quantity(21) | Mag | Smooth
field plots:
  H_Vector1: H on Setup1 : LastAdaptive
reports:
  Calculator Expressions Plot 1: NI vs $dm on Setup1 : LastAdaptive; markers MX1 at x=0.01
   Plot 1: H_mag vs Distance on Setup1 : LastAdaptive
   Plot 2: Mag_H_smooth vs Distance on Setup1 : LastAdaptive
